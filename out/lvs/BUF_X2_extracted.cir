* Extracted by KLayout with SKY130 LVS runset on : 20/07/2026 23:34

.SUBCKT BUF_X2 4 1 3 2 7
M$1 3 4 5 6 sky130_fd_pr__pfet_01v8 L=0.15 W=1.7 AS=0.38675 AD=0.2635 PS=3.46
+ PD=2.32
M$3 3 5 2 6 sky130_fd_pr__pfet_01v8 L=0.15 W=3.4 AS=0.527 AD=0.65025 PS=4.64
+ PD=5.78
M$7 1 4 5 7 sky130_fd_pr__nfet_01v8 L=0.15 W=0.65 AS=0.147875 AD=0.10075
+ PS=1.885 PD=1.27
M$9 1 5 2 7 sky130_fd_pr__nfet_01v8 L=0.15 W=1.3 AS=0.2015 AD=0.248625 PS=2.54
+ PD=3.155
.ENDS BUF_X2
