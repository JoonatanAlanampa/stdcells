.subckt BUF_X1 A Y VPWR VGND VNB
M0 yb A VPWR nwell_i sky130_fd_pr__pfet_01v8 L=0.15u W=1.0u
M1 yb A VGND VNB sky130_fd_pr__nfet_01v8 L=0.15u W=0.65u
M2 Y yb VPWR nwell_i sky130_fd_pr__pfet_01v8 L=0.15u W=1.0u
M3 Y yb VGND VNB sky130_fd_pr__nfet_01v8 L=0.15u W=0.65u
.ends
