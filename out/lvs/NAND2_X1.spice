.subckt NAND2_X1 A B Y VPWR VGND VNB
M0 Y A VPWR nwell_i sky130_fd_pr__pfet_01v8 L=0.15u W=1.0u
M1 Y B VPWR nwell_i sky130_fd_pr__pfet_01v8 L=0.15u W=1.0u
M2 Y A m0 VNB sky130_fd_pr__nfet_01v8 L=0.15u W=0.65u
M3 m0 B VGND VNB sky130_fd_pr__nfet_01v8 L=0.15u W=0.65u
.ends
