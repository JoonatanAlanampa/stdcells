* Extracted by KLayout with SKY130 LVS runset on : 21/07/2026 20:18

.SUBCKT INV_X4 1 2 3 4 6
M$1 3 1 4 5 sky130_fd_pr__pfet_01v8 L=0.15 W=4 AS=0.665 AD=0.665 PS=6.33 PD=6.33
M$5 2 1 4 6 sky130_fd_pr__nfet_01v8 L=0.15 W=2.6 AS=0.43225 AD=0.43225 PS=4.58
+ PD=4.58
.ENDS INV_X4
