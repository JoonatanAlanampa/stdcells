* Extracted by KLayout with SKY130 LVS runset on : 21/07/2026 12:01

.SUBCKT NOR2_X1 5 1 2 4 3 8
M$1 3 1 7 6 sky130_fd_pr__pfet_01v8 L=0.15 W=1 AS=0.26 AD=0.105 PS=2.52 PD=1.21
M$2 7 5 4 6 sky130_fd_pr__pfet_01v8 L=0.15 W=1 AS=0.105 AD=0.26 PS=1.21 PD=2.52
M$3 2 1 3 8 sky130_fd_pr__nfet_01v8 L=0.15 W=0.65 AS=0.169 AD=0.08775 PS=1.82
+ PD=0.92
M$4 3 5 2 8 sky130_fd_pr__nfet_01v8 L=0.15 W=0.65 AS=0.08775 AD=0.169 PS=0.92
+ PD=1.82
.ENDS NOR2_X1
