.subckt NOR2_X1 A B Y VPWR VGND VNB
M0 m0 A VPWR nwell_i sky130_fd_pr__pfet_01v8 L=0.15u W=1.0u
M1 Y B m0 nwell_i sky130_fd_pr__pfet_01v8 L=0.15u W=1.0u
M2 Y A VGND VNB sky130_fd_pr__nfet_01v8 L=0.15u W=0.65u
M3 Y B VGND VNB sky130_fd_pr__nfet_01v8 L=0.15u W=0.65u
.ends
