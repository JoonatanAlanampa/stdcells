.subckt NOR2_X1 A B Y VPWR VGND VNB
M0 VPWR A p1 nwell_i sky130_fd_pr__pfet_01v8 L=0.15u W=0.85u
M1 p1 B Y nwell_i sky130_fd_pr__pfet_01v8 L=0.15u W=0.85u
M2 Y B p2 nwell_i sky130_fd_pr__pfet_01v8 L=0.15u W=0.85u
M3 p2 A VPWR nwell_i sky130_fd_pr__pfet_01v8 L=0.15u W=0.85u
M4 Y A VGND VNB sky130_fd_pr__nfet_01v8 L=0.15u W=0.65u
M5 Y B VGND VNB sky130_fd_pr__nfet_01v8 L=0.15u W=0.65u
.ends
