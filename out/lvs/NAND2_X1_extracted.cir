* Extracted by KLayout with SKY130 LVS runset on : 20/07/2026 23:34

.SUBCKT NAND2_X1 1 5 4 2 3 9
M$1 2 1 3 6 sky130_fd_pr__pfet_01v8 L=0.15 W=1.7 AS=0.38675 AD=0.38675 PS=3.46
+ PD=3.46
M$2 3 5 2 6 sky130_fd_pr__pfet_01v8 L=0.15 W=1.7 AS=0.2635 AD=0.2635 PS=2.32
+ PD=2.32
M$5 4 1 8 9 sky130_fd_pr__nfet_01v8 L=0.15 W=0.65 AS=0.195 AD=0.10075 PS=1.9
+ PD=0.96
M$6 8 5 3 9 sky130_fd_pr__nfet_01v8 L=0.15 W=0.65 AS=0.10075 AD=0.10075 PS=0.96
+ PD=0.96
M$7 3 5 7 9 sky130_fd_pr__nfet_01v8 L=0.15 W=0.65 AS=0.10075 AD=0.10075 PS=0.96
+ PD=0.96
M$8 7 1 4 9 sky130_fd_pr__nfet_01v8 L=0.15 W=0.65 AS=0.10075 AD=0.195 PS=0.96
+ PD=1.9
.ENDS NAND2_X1
