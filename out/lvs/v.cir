* Extracted by KLayout with SKY130 LVS runset on : 20/07/2026 23:30

.SUBCKT INV_X1 A VGND VPWR Y sky130_gnd
M$1 VPWR A Y \$5 sky130_fd_pr__pfet_01v8 L=0.15 W=1.7 AS=0.38675 AD=0.38675
+ PS=3.46 PD=3.46
M$3 VGND A Y sky130_gnd sky130_fd_pr__nfet_01v8 L=0.15 W=0.65 AS=0.147875
+ AD=0.147875 PS=1.885 PD=1.885
.ENDS INV_X1
