* Extracted by KLayout with SKY130 LVS runset on : 21/07/2026 15:20

.SUBCKT TIE_X1 1 2 3 4 6
M$1 4 2 1 5 sky130_fd_pr__pfet_01v8 L=0.15 W=1 AS=0.27 AD=0.26 PS=2.54 PD=2.52
M$2 2 1 3 6 sky130_fd_pr__nfet_01v8 L=0.15 W=0.65 AS=0.169 AD=0.169 PS=1.82
+ PD=1.82
.ENDS TIE_X1
