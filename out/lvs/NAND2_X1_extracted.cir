* Extracted by KLayout with SKY130 LVS runset on : 21/07/2026 20:18

.SUBCKT NAND2_X1 2 1 3 4 5 8
M$1 4 1 5 6 sky130_fd_pr__pfet_01v8 L=0.15 W=1 AS=0.26 AD=0.135 PS=2.52 PD=1.27
M$2 5 2 4 6 sky130_fd_pr__pfet_01v8 L=0.15 W=1 AS=0.135 AD=0.26 PS=1.27 PD=2.52
M$3 3 1 7 8 sky130_fd_pr__nfet_01v8 L=0.15 W=0.65 AS=0.169 AD=0.08775 PS=1.82
+ PD=0.92
M$4 7 2 5 8 sky130_fd_pr__nfet_01v8 L=0.15 W=0.65 AS=0.08775 AD=0.169 PS=0.92
+ PD=1.82
.ENDS NAND2_X1
