* Extracted by KLayout with SKY130 LVS runset on : 21/07/2026 15:49

.SUBCKT DFF_X1 12 13 9 1 15 14 18
M$1 14 13 4 15 sky130_fd_pr__pfet_01v8 L=0.15 W=0.42 AS=0.1092 AD=0.05775
+ PS=1.36 PD=0.695
M$2 4 3 5 15 sky130_fd_pr__pfet_01v8 L=0.15 W=0.42 AS=0.05775 AD=0.06825
+ PS=0.695 PD=0.745
M$3 5 2 16 15 sky130_fd_pr__pfet_01v8 L=0.15 W=0.42 AS=0.06825 AD=0.07665
+ PS=0.745 PD=0.785
M$4 14 6 16 15 sky130_fd_pr__pfet_01v8 L=0.15 W=0.42 AS=0.178875 AD=0.07665
+ PS=1.26 PD=0.785
M$5 14 5 6 15 sky130_fd_pr__pfet_01v8 L=0.15 W=0.75 AS=0.178875 AD=0.1095
+ PS=1.26 PD=1.075
M$6 6 2 7 15 sky130_fd_pr__pfet_01v8 L=0.15 W=0.42 AS=0.1095 AD=0.0567 PS=1.075
+ PD=0.69
M$7 7 3 17 15 sky130_fd_pr__pfet_01v8 L=0.15 W=0.42 AS=0.0567 AD=0.0882 PS=0.69
+ PD=0.84
M$8 17 8 14 15 sky130_fd_pr__pfet_01v8 L=0.15 W=0.42 AS=0.0882 AD=0.1113
+ PS=0.84 PD=1.37
M$9 2 12 14 15 sky130_fd_pr__pfet_01v8 L=0.15 W=0.64 AS=0.1664 AD=0.0864 PS=1.8
+ PD=0.91
M$10 14 2 3 15 sky130_fd_pr__pfet_01v8 L=0.15 W=0.64 AS=0.0864 AD=0.1664
+ PS=0.91 PD=1.8
M$11 8 7 14 15 sky130_fd_pr__pfet_01v8 L=0.15 W=1 AS=0.27 AD=0.135 PS=2.54
+ PD=1.27
M$12 14 8 9 15 sky130_fd_pr__pfet_01v8 L=0.15 W=1 AS=0.135 AD=0.26 PS=1.27
+ PD=2.52
M$13 4 2 5 18 sky130_fd_pr__nfet_01v8 L=0.15 W=0.36 AS=0.0813 AD=0.0621 PS=0.83
+ PD=0.705
M$14 5 3 11 18 sky130_fd_pr__nfet_01v8 L=0.15 W=0.36 AS=0.0621 AD=0.0696
+ PS=0.705 PD=0.765
M$15 6 3 7 18 sky130_fd_pr__nfet_01v8 L=0.15 W=0.36 AS=0.0989 AD=0.0684
+ PS=0.995 PD=0.74
M$16 7 2 10 18 sky130_fd_pr__nfet_01v8 L=0.15 W=0.36 AS=0.0684 AD=0.066 PS=0.74
+ PD=0.745
M$17 1 13 4 18 sky130_fd_pr__nfet_01v8 L=0.15 W=0.42 AS=0.1092 AD=0.0813
+ PS=1.36 PD=0.83
M$18 11 6 1 18 sky130_fd_pr__nfet_01v8 L=0.15 W=0.42 AS=0.0696 AD=0.12095
+ PS=0.765 PD=1.085
M$19 10 8 1 18 sky130_fd_pr__nfet_01v8 L=0.15 W=0.42 AS=0.066 AD=0.1092
+ PS=0.745 PD=1.36
M$20 1 5 6 18 sky130_fd_pr__nfet_01v8 L=0.15 W=0.64 AS=0.12095 AD=0.0989
+ PS=1.085 PD=0.995
M$21 2 12 1 18 sky130_fd_pr__nfet_01v8 L=0.15 W=0.42 AS=0.1092 AD=0.0567
+ PS=1.36 PD=0.69
M$22 1 2 3 18 sky130_fd_pr__nfet_01v8 L=0.15 W=0.42 AS=0.0567 AD=0.1092 PS=0.69
+ PD=1.36
M$23 8 7 1 18 sky130_fd_pr__nfet_01v8 L=0.15 W=0.65 AS=0.169 AD=0.08775 PS=1.82
+ PD=0.92
M$24 1 8 9 18 sky130_fd_pr__nfet_01v8 L=0.15 W=0.65 AS=0.08775 AD=0.169 PS=0.92
+ PD=1.82
.ENDS DFF_X1
